*  cd ../../Users/Asus/Desktop/NGSpice/ckt-inversor/Xyce

.include "finfet.mod"
* Declaração das fontes
.param supply = 0.7

vdd vdd 0 dc 0.7
vin1 in1 0 PULSE (0 0.7 0p 10p 10p 1000p 1000p)
vin2 in2 0 PULSE (0 0. 0p 10p 10p 1000p 1000p)
.tran 0.001p 1000p

MP1 out     in1 vdd     vdd pmos_lvt L=20n NFIN=2
MP2 out     in2 vdd     vdd pmos_lvt L=20n NFIN=2
MN1 out     in1 n1      n1  nmos_lvt L=20n NFIN=2
MN2 n1      in2 0       0   nmos_lvt L=20n NFIN=2

vaux n1 aux 0
* Positivo

*iexp out dnmos exp(0 10u 50p 2p 65p 4p)
* Negativo
iexp2 aux 0 exp(0 49u 20p 2p 35p 4p)

.OPTION OUTPUT INITIAL_INTERVAL=.1ps 350ps
.PRINT TRAN FORMAT=CSV v(out) v(in1) v(in2)
.measure tran valor_maximo MAX v(out) from=0n to=100p
.measure tran valor_minimo MIN v(out) from=0n to=100p
.end
