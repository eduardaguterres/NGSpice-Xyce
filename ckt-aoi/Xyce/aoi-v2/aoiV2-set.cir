*  cd ../../Users/Asus/Desktop/NGSpice/ckt-aoi/Xyce/aoi-v2

.include "finfet.mod"

* Declaração das fontes
.param supply = 0.7
vdd vdd 0 dc 0.7
* Variando Inv1
vin1 in1 0 PULSE (0 0. 0p 10p 10p 1200p 600p)
vin2 in2 0 PULSE (0 0. 0p 10p 10p 1200p 1200p)
vin3 in3 0 PULSE (0 0.7 0p 10p 10p 1200p 2400p)

.tran 0.001p 100p

Vagingp1 in1 inp1 dc -0.0445
Vagingp2 in2 inp2 dc -0.0397
Vagingp3 in3 inp3 dc -0.0397
Vagingn1 in1 inn1 dc 0.0445
Vagingn2 in2 inn2 dc 0.0425
Vagingn3 in3 inn3 dc 0.0445

MP1 n1 inp1 vdd vdd pmos_lvt L=20n NFIN=2
MP2 out inp2 n1 vdd pmos_lvt L=20n NFIN=2
MP3 out inp3 n1 vdd pmos_lvt L=20n NFIN=2

MN1 out inn1 0 0 nmos_lvt L=20n NFIN=2
MN2 out inn2 n2 0 nmos_lvt L=20n NFIN=2
MN3 n2 inn3 0 0 nmos_lvt L=20n NFIN=2

*Variando In1
vaux n1 aux 0
* Positivo
iexp 0 aux exp(0 50u 50p 2p 65p 4p)
* Negativo
*iexp2 aux 0 exp(0 61u 50p 2p 65p 4p)

.OPTION OUTPUT INITIAL_INTERVAL=.1ps 350ps
.PRINT TRAN FORMAT=CSV v(out) v(in1) v(in2) v(in3) v(n1) v(n2)
.measure tran valor_maximo MAX v(out) from=50p to=65p
.measure tran valor_minimo MIN v(out) from=50p to=65p
.measure tran valor_max_n1 MAX v(n1) from=50p to=65p
.measure tran valor_min_n1 MIN v(n1) from=50p to=65p
.measure tran valor_max_n2 MAX v(n2) from=50p to=65p
.measure tran valor_min_n2 MIN v(n2) from=50p to=65p

.end
